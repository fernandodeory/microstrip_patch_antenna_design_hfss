# Ansys Electronics Desktop project, version 2025.2
materials:
  vacuum: permittivity=1
  FR4_epoxy: permittivity=4.4 dielectric_loss_tangent=0.02
  PMLGroup1_Z_1: permittivity{anisotropic component1=1.1631806 component2=1.1631806 component3=0.42985587} permeability{anisotropic component1=1.1631806 component2=1.1631806 component3=0.42985587} dielectric_loss_tangent{anisotropic component1=1 component2=1 component3=-1} magnetic_loss_tangent{anisotropic component1=1 component2=1 component3=-1}
  PMLGroup1_XZ_1: permittivity{anisotropic component1=1 component2=0.01 component3=1} permeability{anisotropic component1=1 component2=0.01 component3=1} dielectric_loss_tangent{anisotropic component1=0 component2=270.59782 component3=0} magnetic_loss_tangent{anisotropic component1=0 component2=270.59782 component3=0}
  PMLGroup1_YZ_1: permittivity{anisotropic component1=0.01 component2=1 component3=1} permeability{anisotropic component1=0.01 component2=1 component3=1} dielectric_loss_tangent{anisotropic component1=270.59782 component2=0 component3=0} magnetic_loss_tangent{anisotropic component1=270.59782 component2=0 component3=0}
  PMLGroup1_XYZ_1: permittivity{anisotropic component1=1.1631806 component2=1.1631806 component3=1.1631806} permeability{anisotropic component1=1.1631806 component2=1.1631806 component3=1.1631806} dielectric_loss_tangent{anisotropic component1=1 component2=1 component3=1} magnetic_loss_tangent{anisotropic component1=1 component2=1 component3=1}

design HFSSDesign1 (HFSS, HFSS Terminal Network, model units mm)
variables:
  wP = 37.26004mm
  lP = 27.8mm
  hP = 35um
  dI = 7.5mm
  wI = 5mm
  wF = 1.5mm
  lF = 10mm
  wS = wP*1.5
  lS = lP+lF*2
  hS = 1.57mm
geometry:
  patch = rectangle(corner=(-wP/2, -lP/2, 0mm), x_size=wP, y_size=lP)
  Rectangle2 = rectangle(corner=(-wI/2, -lP/2-dI/2, 0mm), x_size=wI, y_size=dI)
  patch.subtract(Rectangle2)
  patch_1 = rectangle(corner=(-wF/2, -lP/2-lF, 0mm), x_size=wF, y_size=dI/2+lF)
  substrate [FR4_epoxy] = box(corner=(-wS/2, -lS/2, -hS), size=(wS, lS, hS))
  GND = rectangle(corner=(-wS/2, -lS/2, -hS), x_size=wS, y_size=lS)
  port = rectangle(corner=(-wF/2, -lS/2, -hS), z_size=hS, x_size=wF)
  RadiatingSurface [vacuum] = region(absolute_offset=30.612245mm on all sides)
  coordinate_system FaceCS1 = face of RadiatingSurface: Origin=(58.557275, -55.032515, 30.612245) FaceID=RadiatingSurface.face(+z) AxisPosn=(58.557275, 55.032515, 30.612245) WhichAxis=X ZRotationAngle=0deg XOffset=0mm YOffset=0mm FaceNormal(0, 0, 1)
  PML_RadiatingSurface_1 [PMLGroup1_Z_1, oriented by FaceCS1] = sweep_along_normal(RadiatingSurface.face(+z), length=47.071119mm)
  coordinate_system FaceCS2 = face of RadiatingSurface: Origin=(58.557275, -55.032515, -32.182245) FaceID=RadiatingSurface.face(-z) AxisPosn=(-58.557275, -55.032515, -32.182245) WhichAxis=X ZRotationAngle=0deg XOffset=0mm YOffset=0mm FaceNormal(0, 0, -1)
  PML_RadiatingSurface_2 [PMLGroup1_Z_1, oriented by FaceCS2] = sweep_along_normal(RadiatingSurface.face(-z), length=47.071119mm)
  coordinate_system FaceCS3 = face of RadiatingSurface: Origin=(58.557275, -55.032515, 30.612245) FaceID=RadiatingSurface.face(-y) AxisPosn=(-58.557275, -55.032515, 30.612245) WhichAxis=X ZRotationAngle=0deg XOffset=0mm YOffset=0mm FaceNormal(0, -1, 0)
  PML_RadiatingSurface_3 [PMLGroup1_Z_1, oriented by FaceCS3] = sweep_along_normal(RadiatingSurface.face(-y), length=47.071119mm)
  coordinate_system FaceCS4 = face of RadiatingSurface: Origin=(-58.557275, -55.032515, 30.612245) FaceID=RadiatingSurface.face(-x) AxisPosn=(-58.557275, 55.032515, 30.612245) WhichAxis=X ZRotationAngle=0deg XOffset=0mm YOffset=0mm FaceNormal(-1, 0, 0)
  PML_RadiatingSurface_4 [PMLGroup1_Z_1, oriented by FaceCS4] = sweep_along_normal(RadiatingSurface.face(-x), length=47.071119mm)
  coordinate_system FaceCS5 = face of RadiatingSurface: Origin=(-58.557275, 55.032515, 30.612245) FaceID=RadiatingSurface.face(+y) AxisPosn=(58.557275, 55.032515, 30.612245) WhichAxis=X ZRotationAngle=0deg XOffset=0mm YOffset=0mm FaceNormal(0, 1, 0)
  PML_RadiatingSurface_5 [PMLGroup1_Z_1, oriented by FaceCS5] = sweep_along_normal(RadiatingSurface.face(+y), length=47.071119mm)
  coordinate_system FaceCS6 = face of RadiatingSurface: Origin=(58.557275, 55.032515, -32.182245) FaceID=RadiatingSurface.face(+x) AxisPosn=(58.557275, 55.032515, 30.612245) WhichAxis=X ZRotationAngle=0deg XOffset=0mm YOffset=0mm FaceNormal(1, 0, 0)
  PML_RadiatingSurface_6 [PMLGroup1_Z_1, oriented by FaceCS6] = sweep_along_normal(RadiatingSurface.face(+x), length=47.071119mm)
  PML_RadiatingSurface_7 [PMLGroup1_XZ_1, oriented by FaceCS1] = sweep_along_normal(PML_RadiatingSurface_1.face(at (0, -55.0325, 54.1478)), length=47.071119mm)
  PML_RadiatingSurface_8 [PMLGroup1_YZ_1, oriented by FaceCS4] = sweep_along_normal(PML_RadiatingSurface_1.face(at (-58.5573, 0, 54.1478)), length=47.071119mm)
  PML_RadiatingSurface_9 [PMLGroup1_YZ_1, oriented by FaceCS5] = sweep_along_normal(PML_RadiatingSurface_1.face(at (0, 55.0325, 54.1478)), length=47.071119mm)
  PML_RadiatingSurface_10 [PMLGroup1_YZ_1, oriented by FaceCS1] = sweep_along_normal(PML_RadiatingSurface_1.face(at (58.5573, 0, 54.1478)), length=47.071119mm)
  PML_RadiatingSurface_11 [PMLGroup1_YZ_1, oriented by FaceCS2] = sweep_along_normal(PML_RadiatingSurface_2.face(at (0, -55.0325, -55.7178)), length=47.071119mm)
  coordinate_system FaceCS7 = face of RadiatingSurface: Origin=(-58.557275, -55.032515, -32.182245) FaceID=RadiatingSurface.face(-z) AxisPosn=(-58.557275, 55.032515, -32.182245) WhichAxis=X ZRotationAngle=0deg XOffset=0mm YOffset=0mm FaceNormal(0, 0, -1)
  PML_RadiatingSurface_12 [PMLGroup1_YZ_1, oriented by FaceCS7] = sweep_along_normal(PML_RadiatingSurface_2.face(at (-58.5573, 0, -55.7178)), length=47.071119mm)
  coordinate_system FaceCS8 = face of RadiatingSurface: Origin=(-58.557275, 55.032515, -32.182245) FaceID=RadiatingSurface.face(-z) AxisPosn=(58.557275, 55.032515, -32.182245) WhichAxis=X ZRotationAngle=0deg XOffset=0mm YOffset=0mm FaceNormal(0, 0, -1)
  PML_RadiatingSurface_13 [PMLGroup1_YZ_1, oriented by FaceCS8] = sweep_along_normal(PML_RadiatingSurface_2.face(at (0, 55.0325, -55.7178)), length=47.071119mm)
  PML_RadiatingSurface_14 [PMLGroup1_XZ_1, oriented by FaceCS2] = sweep_along_normal(PML_RadiatingSurface_2.face(at (58.5573, 0, -55.7178)), length=47.071119mm)
  PML_RadiatingSurface_15 [PMLGroup1_XZ_1, oriented by FaceCS4] = sweep_along_normal(PML_RadiatingSurface_3.face(at (-58.5573, -78.5681, -0.785)), length=47.071119mm)
  PML_RadiatingSurface_16 [PMLGroup1_XZ_1, oriented by FaceCS3] = sweep_along_normal(PML_RadiatingSurface_3.face(at (58.5573, -78.5681, -0.785)), length=47.071119mm)
  PML_RadiatingSurface_17 [PMLGroup1_XZ_1, oriented by FaceCS5] = sweep_along_normal(PML_RadiatingSurface_4.face(at (-82.0928, 55.0325, -0.785)), length=47.071119mm)
  PML_RadiatingSurface_18 [PMLGroup1_YZ_1, oriented by FaceCS6] = sweep_along_normal(PML_RadiatingSurface_5.face(at (58.5573, 78.5681, -0.785)), length=47.071119mm)
  PML_RadiatingSurface_19 [PMLGroup1_XYZ_1, oriented by FaceCS4] = sweep_along_normal(PML_RadiatingSurface_7.face(at (-58.5573, -78.5681, 54.1478)), length=47.071119mm)
  PML_RadiatingSurface_20 [PMLGroup1_XYZ_1, oriented by FaceCS1] = sweep_along_normal(PML_RadiatingSurface_7.face(at (58.5573, -78.5681, 54.1478)), length=47.071119mm)
  PML_RadiatingSurface_21 [PMLGroup1_XYZ_1, oriented by FaceCS5] = sweep_along_normal(PML_RadiatingSurface_8.face(at (-82.0928, 55.0325, 54.1478)), length=47.071119mm)
  coordinate_system FaceCS9 = face of RadiatingSurface: Origin=(58.557275, 55.032515, 30.612245) FaceID=RadiatingSurface.face(+z) AxisPosn=(-58.557275, 55.032515, 30.612245) WhichAxis=X ZRotationAngle=0deg XOffset=0mm YOffset=0mm FaceNormal(0, 0, 1)
  PML_RadiatingSurface_22 [PMLGroup1_XYZ_1, oriented by FaceCS9] = sweep_along_normal(PML_RadiatingSurface_9.face(at (58.5573, 78.5681, 54.1478)), length=47.071119mm)
  PML_RadiatingSurface_23 [PMLGroup1_XYZ_1, oriented by FaceCS7] = sweep_along_normal(PML_RadiatingSurface_11.face(at (-58.5573, -78.5681, -55.7178)), length=47.071119mm)
  PML_RadiatingSurface_24 [PMLGroup1_XYZ_1, oriented by FaceCS2] = sweep_along_normal(PML_RadiatingSurface_11.face(at (58.5573, -78.5681, -55.7178)), length=47.071119mm)
  PML_RadiatingSurface_25 [PMLGroup1_XYZ_1, oriented by FaceCS8] = sweep_along_normal(PML_RadiatingSurface_12.face(at (-82.0928, 55.0325, -55.7178)), length=47.071119mm)
  PML_RadiatingSurface_26 [PMLGroup1_XYZ_1, oriented by FaceCS6] = sweep_along_normal(PML_RadiatingSurface_13.face(at (58.5573, 78.5681, -55.7178)), length=47.071119mm)
  patch_1.unite(patch)
  group PMLGroup1 = PML_RadiatingSurface_1..PML_RadiatingSurface_26
boundaries and excitations:
  PML_radiation1: Radiation Faces=RadiatingSurface.face(+z) IsForPML
  PML_radiation2: Radiation Faces=RadiatingSurface.face(-z) IsForPML
  PML_radiation3: Radiation Faces=RadiatingSurface.face(-y) IsForPML
  PML_radiation4: Radiation Faces=RadiatingSurface.face(-x) IsForPML
  PML_radiation5: Radiation Faces=RadiatingSurface.face(+y) IsForPML
  PML_radiation6: Radiation Faces=RadiatingSurface.face(+x) IsForPML
  PerfE1: Perfect E Objects=GND
  PerfE2: Perfect E Objects=patch_1
  1: Lumped Port Objects=port LumpedPortType=Modal Modes{Mode1{IntLine{(0, -23.9, -1.57) -> (0, -23.9, 0)} CharImp=Zpi RenormImp=50ohm}} Impedance=50ohm
setups:
  Setup1: HfssDriven Frequency=2.45GHz MaxDeltaS=0.02 MaximumPasses=6 MinimumPasses=1 MinimumConvergedPasses=1 PercentRefinement=30 BasisOrder=1 PortAccuracy=2 DrivenSolverType="Direct Solver"
    sweep Sweep: 1.85GHz to 3.05GHz, 401 points; Type=Interpolating InterpTolerance=0.5 InterpMaxSolns=250 PassivityErrorTolerance=0.0001
source amplitudes:
  1:1: 1V 0deg
optimetrics:
  ParametricSetup1: Parametric Sim._Setups=[Setup1]
    sweep wF: LIN 0.5mm 2mm 0.2mm
radiation setups:
  3D: Infinite Sphere Theta=0deg..180deg step 2deg Phi=-180deg..180deg step 2deg
  Elevation: Infinite Sphere Theta=-180deg..180deg step 1deg Phi=0deg..90deg step 90deg
  Azimuth: Infinite Sphere Theta=90deg..90deg step 0deg Phi=-180deg..180deg step 1deg
  p_plane: Infinite Sphere Theta=-180deg..180deg step 2deg Phi=0deg..0deg step 0deg
reports:
  Z Parameter Plot1: re(Z(1,1)), im(Z(1,1)) vs Freq on Setup1 : Sweep
  S Parameter Plot1: dB(S(1,1)) vs Freq on Setup1 : Sweep [lP=27.8mm wF=0.5mm,0.7mm,0.9mm,1.1mm,1.3mm,1.5mm,1.7mm,1.9mm,2mm,2.5mm]; markers m1 at 2.372GHz, m2 at 2.435GHz, m3 at 2.444GHz, m4 at 2.45GHz, m5 at 2.45GHz
  S Parameter Plot2: dB(S(1,1)) vs Freq on Setup1 : Sweep [dI=7.5mm wF=1.5mm]; markers m1 at 2.36GHz
  Z Parameter Plot2: re(Z(1,1)) vs Freq on Setup1 : Sweep [lP=27.8mm dI=7.5mm wF=1.5mm]; im(Z(1,1)) vs Freq on Setup1 : Sweep [dI=7.5mm wF=1.5mm]; markers m1 at 2.36GHz, m2 at 2.45GHz, m3 at 2.426GHz
  Gain Plot1: dB(GainTotal) vs Theta on Setup1 : LastAdaptive, p_plane
  Directivity Plot1: dB(DirTotal) vs Phi, Theta on Setup1 : LastAdaptive, 3D [Freq=2.45GHz lP=27.8mm dI=2.5mm wF=1.5mm]
  Directivity Plot2: dB(DirTotal) vs Phi, Theta on Setup1 : LastAdaptive, 3D [Freq=2.45GHz lP=27.8mm dI=7.5mm wF=1.5mm]
